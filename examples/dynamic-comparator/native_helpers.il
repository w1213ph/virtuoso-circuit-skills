procedure(cmpSetParams(cv name pairs)
 let((ii iCDF cdfgData cdfgForm p cb)
  ii=car(setof(x cv~>instances x~>name==name))
  unless(ii error("Missing instance %s" name))
  iCDF=cdfGetInstCDF(ii) cdfgData=iCDF cdfgForm=nil
  when(iCDF~>formInitProc && iCDF~>formInitProc!="" funcall(concat(iCDF~>formInitProc) iCDF))
  foreach(pair pairs
   p=cdfFindParamByName(iCDF car(pair))
   unless(p error("Missing CDF parameter %s/%s" name car(pair)))
   p~>value=cadr(pair) cb=p~>callback
   when(cb && cb!="" unless(errset(evalstring(cb) t) error("CDF callback failed %s/%s" name car(pair))))
  )
  cdfUpdateInstParam(ii) t
 )
)

procedure(cmpJson(v) let((s ch out i first)
 cond((v==nil "null")
 (stringp(v) out="\"" for(i 1 strlen(v) ch=substring(v i 1)
 cond((ch=="\\" out=strcat(out "\\\\")) (ch=="\"" out=strcat(out "\\\""))
 (ch=="\n" out=strcat(out "\\n")) (ch=="\r" out=strcat(out "\\r"))
 (ch=="\t" out=strcat(out "\\t")) (t out=strcat(out ch)))) strcat(out "\""))
 (numberp(v) sprintf(nil "%.12g" float(v)))
 (listp(v) out="[" first=t foreach(s v unless(first out=strcat(out ",")) out=strcat(out cmpJson(s)) first=nil) strcat(out "]"))
 (t cmpJson(sprintf(nil "%L" v))))))
procedure(cmpPinXY(ii tt) let((bb)
 bb=car(car(tt~>pins)~>figs)~>bBox
 if(ii dbTransformPoint(centerBox(bb) ii~>transform) if(car(car(tt~>pins)~>figs)~>objType=="inst" car(car(tt~>pins)~>figs)~>xy centerBox(bb)))))
procedure(cmpReadView(cv file) let((f comma comma2 pts)
 f=outfile(file) fprintf(f "{\"cell\":%s,\"dbu\":%s,\"bbox\":%s,\"instances\":[" cmpJson(cv~>cellName) cmpJson(cv~>DBUPerUU) cmpJson(cv~>bBox))
 comma="" foreach(ii cv~>instances
 fprintf(f "%s{\"name\":%s,\"lib\":%s,\"cell\":%s,\"xy\":%s,\"orient\":%s,\"bbox\":%s,\"terms\":[" comma cmpJson(ii~>name) cmpJson(ii~>libName) cmpJson(ii~>cellName) cmpJson(ii~>xy) cmpJson(ii~>orient) cmpJson(ii~>bBox))
 comma2="" foreach(it ii~>instTerms fprintf(f "%s{\"name\":%s,\"net\":%s,\"xy\":%s}" comma2 cmpJson(it~>name) cmpJson(it~>net~>name) cmpJson(cmpPinXY(ii it~>term))) comma2=",")
 fprintf(f "],\"props\":[") comma2=""
 foreach(pp ii~>prop fprintf(f "%s[%s,%s,%s]" comma2 cmpJson(pp~>name) cmpJson(pp~>valueType) cmpJson(pp~>value)) comma2=",")
 fprintf(f "]}") comma=",")
 fprintf(f "],\"ports\":[") comma=""
 foreach(tt cv~>terminals fprintf(f "%s{\"name\":%s,\"direction\":%s,\"net\":%s,\"xy\":%s}" comma cmpJson(tt~>name) cmpJson(tt~>direction) cmpJson(tt~>net~>name) cmpJson(cmpPinXY(nil tt))) comma=",")
 fprintf(f "],\"shapes\":[") comma=""
 foreach(ss cv~>shapes
 fprintf(f "%s{\"type\":%s,\"lpp\":%s,\"net\":%s,\"xy\":%s,\"points\":%s,\"text\":%s,\"bbox\":%s}" comma cmpJson(ss~>objType) cmpJson(ss~>lpp) cmpJson(ss~>net~>name) cmpJson(ss~>xy) cmpJson(ss~>points) cmpJson(ss~>theLabel) cmpJson(ss~>bBox)) comma=",")
 fprintf(f "]}") close(f) t))

procedure(cmpInst(lib master name xy orient)
  let((m) m=dbOpenCellViewByType(lib master "symbol" "" "r")
    unless(m error("Missing %s/%s" lib master))
    unless(dbCreateInst(cv m name xy orient) error("Instance failed %s" name))))
procedure(cmpProperty(name key value)
  dbReplaceProp(dbFindAnyInstByName(cv name) key "string" value))
procedure(cmpWire(pts name at justify)
  let((w)
    w=schCreateWire(cv "draw" "full" pts 0 0 0 nil nil)
    unless(w error("Invalid wire %L" pts))
    when(name schCreateWireLabel(cv nil at name justify "R0" "roman" 0.105 nil))
    t
  ))
procedure(cmpSymbolPin(name direction box)
  let((net term figure)
    net=dbCreateNet(cv name)
    term=dbCreateTerm(net name direction)
    figure=dbCreateRect(cv list("pin" "drawing") box)
    unless(dbCreatePin(net figure name term) error("Symbol pin failed %s" name))))

procedure(cmpCheckPDK(pdk)
  let((cv cdf terminal expectedY)
    foreach(cell '("n18" "p18")
      cv=dbOpenCellViewByType(pdk cell "symbol" "" "r")
      unless(cv && cv~>DBUPerUU==160 error("Unexpected %s/%s symbol grid" pdk cell))
      cdf=cdfGetBaseCellCDF(ddGetObj(pdk cell))
      foreach(key '("l" "fw" "w" "fingers" "m")
        unless(cdfFindParamByName(cdf key) error("Missing CDF %s/%s" cell key)))
      unless(length(cv~>terminals)==4 error("Expected a four-terminal MOS"))
      expectedY=if(equal(cell "n18") 0.1875 -0.1875)
      foreach(pair list(list("D" list(0.25 expectedY)) list("G" list(0.0 0.0))
                        list("S" list(0.25 -expectedY)) list("B" list(0.25 0.0)))
        terminal=dbFindTermByName(cv car(pair))
        unless(terminal && equal(cmpPinXY(nil terminal) cadr(pair))
          error("Unexpected anchor %s/%s" cell car(pair))))
      printf("CMP_PDK %s/%s grid=%L D/G/S/B and CDF verified\n" pdk cell cv~>DBUPerUU)
      dbClose(cv))
    t))
