; Each invocation owns one fresh comparator workspace and one ADE session.
procedure(cmpConfigure()
  let((session name)
    session=maeOpenSetup(cmpLib cmpTB "maestro" ?mode "a")
    unless(session error("Cannot open comparator Maestro view"))
    foreach(row cmpCases
      name=car(row)
      maeCreateTest(name ?lib cmpLib ?cell cmpTB ?view "schematic" ?simulator "spectre" ?session session)
      maeSetEnvOption(name ?options list(
        list("modelFiles" list(list(cmpModel cmpCorner) list(cmpSaves "")))
        list("switchViewList" '("spectre" "veriloga" "schematic"))
        list("stopViewList" '("spectre" "veriloga")) list("controlMode" "batch")
        list("simExecName" cmpSpectre) list("userCmdLineOption" "+mt=1 -format psfascii")) ?session session)
      maeSetSimOption(name ?options list(list("temp" cmpTemp) list("reltol" "1e-5")
        list("vabstol" "1e-7") list("iabstol" "1e-13")) ?session session)
      maeSetAnalysis(name "tran" ?enable t ?options '(("stop" "39n") ("maxstep" "5p")
        ("strobeperiod" "5p") ("strobeoutput" "strobeonly") ("errpreset" "conservative")) ?session session)
      foreach(pair cadr(row)
        maeSetVar(car(pair) cadr(pair) ?typeName "test" ?typeValue list(name) ?session session))
      maeSetEnableTestVar(name mapcar('car cadr(row)) ?enabled t ?session session)
      foreach(net '("CLK" "VDD" "SRC_P" "SRC_N" "INP" "INN" "OUTP" "OUTN")
        maeAddOutput(net name ?outputType "net" ?signalName strcat("/" net)
          ?save t ?plot t ?session session)))
    maeSetSetup(?tests mapcar('car cmpCases) ?enabled t ?session session)
    unless(maeSaveSetup(?session session) error("Cannot save comparator Maestro view"))
    maeCloseSession(?session session)))

procedure(cmpRun()
  let((session history stream name)
    session=maeOpenSetup(cmpLib cmpTB "maestro" ?mode "a")
    unless(session error("Cannot reopen comparator Maestro view"))
    stream=outfile(cmpReadback)
    foreach(row cmpCases
      name=car(row)
      fprintf(stream "%s %L %L\n" name maeGetAnalysis(name "tran" ?session session)
        maeGetEnvOption(name ?option "modelFiles" ?session session)))
    close(stream)
    history=maeRunSimulation(?session session)
    unless(history error("Missing Maestro history"))
    maeWaitUntilDone(history ?session session)
    stream=outfile(cmpHistory)
    fprintf(stream "%L\n%L\n" history maeGetSimulationMessages(?session session ?msgType "ALL"))
    close(stream)
    maeCloseSession(?session session)))
