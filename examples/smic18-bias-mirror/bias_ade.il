procedure(biasConfigure()
  let((session name mode corner temp values saves)
    unless(equal(ddGetObj(biasLib)~>readPath strcat(getWorkingDir() "/" biasLib))
      error("Target ADE library must be inside this candidate directory"))
    session=maeOpenSetup(biasLib biasTB "maestro" ?mode "a")
    unless(session error("Cannot create local bias Maestro view"))
    foreach(row biasTests
      name=car(row) mode=cadr(row) corner=caddr(row) temp=cadddr(row)
      values=nth(4 row) saves=if(equal(mode "dc") biasDCSaves biasTranSaves)
      maeCreateTest(name ?lib biasLib ?cell biasTB ?view "schematic" ?simulator "spectre" ?session session)
      maeSetEnvOption(name ?options list(list("modelFiles" list(list(biasModel corner) list(saves "")))
        list("switchViewList" '("spectre" "veriloga" "schematic")) list("stopViewList" '("spectre" "veriloga"))
        list("controlMode" "batch") list("simExecName" biasSpectre)
        list("userCmdLineOption" "+mt=1 -format psfascii")) ?session session)
      maeSetSimOption(name ?options list(list("temp" temp) list("reltol" "1e-5")
        list("vabstol" "1e-7") list("iabstol" "1e-13")) ?session session)
      if(equal(mode "dc")
        maeSetAnalysis(name "dc" ?enable t ?options '(("sweep" "Design Variable") ("param" "VOUT") ("start" "0") ("stop" "1.5")
          ("step" "0.01") ("incrType" "Linear")) ?session session)
        maeSetAnalysis(name "tran" ?enable t ?options list(list("stop" biasStop) '("maxstep" "200p")
          '("strobeperiod" "200p") '("strobeoutput" "strobeonly") '("errpreset" "conservative")) ?session session))
      foreach(pair values maeSetVar(car(pair) cadr(pair) ?typeName "test" ?typeValue list(name) ?session session))
      maeSetEnableTestVar(name mapcar('car values) ?enabled t ?session session)
      maeAddOutput("VREF_NODE" name ?outputType "net" ?signalName "/IREF" ?save t ?plot t ?session session)
      maeAddOutput("IOUT_SINK" name ?outputType "point"
        ?expr if(equal(mode "dc") "-IS(\"/VFORCE/PLUS\")" "-IT(\"/VFORCE/PLUS\")") ?plot t ?session session))
    maeSetSetup(?tests mapcar('car biasTests) ?enabled t ?session session)
    unless(maeSaveSetup(?session session) error("Cannot save bias test setup"))
    maeCloseSession(?session session)))

procedure(biasRun()
  let((session hist stream)
    session=maeOpenSetup(biasLib biasTB "maestro" ?mode "a")
    unless(session error("Cannot reopen saved bias Maestro view"))
    stream=outfile(biasReadback)
    foreach(row biasTests
      fprintf(stream "%s %L %L\n" car(row) maeGetAnalysis(car(row) cadr(row) ?session session)
          maeGetEnvOption(car(row) ?option "modelFiles" ?session session)))
    close(stream)
    hist=maeRunSimulation(?session session)
    unless(hist error("Maestro did not start a recorded history"))
    maeWaitUntilDone(hist ?session session)
    stream=outfile(biasHistory)
    fprintf(stream "%L\n%L\n" hist maeGetSimulationMessages(?session session ?msgType "ALL"))
    close(stream)
    maeCloseSession(?session session)))
