procedure(fdConfigure()
  let((s name ana corner models settings saves variables outputs)
    unless(equal(ddGetObj(fdLib)~>readPath strcat(getWorkingDir() "/" fdLib))
      error("ADE target must be the local candidate library"))
    s=maeOpenSetup(fdLib fdTB "maestro" ?mode "a")
    unless(s error("Cannot create OTA Maestro view"))
    foreach(row fdTests
      name=car(row) ana=cadr(row) corner=caddr(row) settings=nth(4 row)
      saves=nth(5 row) variables=nth(6 row) outputs=nth(7 row)
      models=list(list(fdModel corner) list(fdModel strcat("res_" corner)) list(fdModel strcat("mim_" corner)) list(saves ""))
      maeCreateTest(name ?lib fdLib ?cell fdTB ?view "schematic" ?simulator "spectre" ?session s)
      maeSetEnvOption(name ?options list(list("modelFiles" models)
        list("switchViewList" '("spectre" "veriloga" "schematic")) list("stopViewList" '("spectre" "veriloga"))
        list("controlMode" "batch") list("simExecName" fdSpectre) list("userCmdLineOption" "+mt=1 -format psfascii")) ?session s)
      maeSetSimOption(name ?options list(list("temp" cadddr(row)) '("reltol" "1e-5") '("vabstol" "1e-7")
        '("iabstol" "1e-13") '("gmin" "")) ?session s)
      maeSetAnalysis(name ana ?enable t ?options settings ?session s)
      foreach(pair variables maeSetVar(car(pair) cadr(pair) ?typeName "test" ?typeValue list(name) ?session s))
      maeSetEnableTestVar(name mapcar('car variables) ?enabled t ?session s)
      foreach(out outputs
        maeAddOutput(car(out) name ?outputType "point" ?expr cadr(out) ?plot t ?session s)))
    maeSetSetup(?tests mapcar('car fdTests) ?enabled t ?session s)
    unless(maeSaveSetup(?session s) error("Cannot save OTA Maestro setup"))
    maeCloseSession(?session s)))

procedure(fdRun()
  let((s hist f)
    s=maeOpenSetup(fdLib fdTB "maestro" ?mode "a")
    unless(s error("Cannot reopen the OTA setup"))
    f=outfile(fdReadback)
    foreach(row fdTests
      fprintf(f "%s %L %L\n" car(row) maeGetAnalysis(car(row) cadr(row) ?session s)
              maeGetEnvOption(car(row) ?option "modelFiles" ?session s))) close(f)
    hist=maeRunSimulation(?session s)
    unless(hist error("Maestro simulation history did not start"))
    maeWaitUntilDone(hist ?session s)
    f=outfile(fdHistory) fprintf(f "%L\n%L\n" hist maeGetSimulationMessages(?session s ?msgType "ALL")) close(f)
    maeCloseSession(?session s)))
